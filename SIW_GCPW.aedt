# Ansys Electronics Desktop project, version 2021.2
materials:
  vacuum: permittivity=1
  Rogers RO4003 (tm): permittivity=3.55 dielectric_loss_tangent=0.0027
  copper: permeability=0.999991 conductivity=58000000
  air: permittivity=1.0006 permeability=1.0000004
  pec: conductivity=1e+30
  Rogers RT/duroid 5880 (tm): permittivity=2.2 dielectric_loss_tangent=0.0009

design original (HFSS, DrivenModal, model units mm)
variables:
  m_length = 20mm
  m_width = 15mm
  m_thickness = 1.524mm
  line_thickness = 0.035mm
  ML_length = 3.25mm
  ML_width = 1.5mm
  gap_width = 0.35mm
  I2 = 5.5mm
  W7 = 2.8mm
  W2 = 4.6mm
  via_radius = 0.15mm
  w5 = -11.12mm
geometry:
  medium [Rogers RT/duroid 5880 (tm)] = box(corner=(-m_length/2, -m_width/2, - m_thickness/2), size=(m_length, m_width, m_thickness))
  layer1 [copper] = box(corner=(-m_length/2, -m_width/2, m_thickness/2), size=(m_length, m_width, line_thickness))
  layer2 [copper] = box(corner=(-m_length/2, -m_width/2, - m_thickness/2 - line_thickness), size=(m_length, m_width, line_thickness))
  gap_1 = box(corner=(m_length/2- ML_length, -ML_width/2 - gap_width, m_thickness/2), size=(ML_length, gap_width, line_thickness))
  gap_1_1 = rectangle(corner=(m_length/2- ML_length, -ML_width/2 - gap_width, m_thickness/2), y_size=gap_width, z_size=line_thickness)
  Rectangle_2 = rectangle(corner=(m_length/2- ML_length - I2, -W2/2-W7, m_thickness/2), y_size=W7, z_size=line_thickness)
  gap_1_1.connect(Rectangle_2)
  gap_1.unite(gap_1_1)
  gap_2 = gap_1.duplicate_mirror(point=(0mm, 0mm, 0mm), normal=(0mm, 1mm, 0mm))
  layer1.subtract(gap_1, gap_2)
  via [copper] = cylinder(axis=Z, base_centre=(m_length/2 -via_radius*2, - ML_width /2 - gap_width - via_radius*2, -m_thickness/2), radius=via_radius, height=m_thickness)
  via_1..via_6 = via.duplicate_along_line(step=(-0.5mm, 0mm, 0mm), total=7)
  via_6_1..via_6_16 = via_6.duplicate_along_line(step=(-0.35mm, -0.26mm, 0mm), total=20)  # copies kept: 1..16
  via_6_16_1..via_6_16_22 = via_6_16.duplicate_along_line(step=(-0.49mm, 0mm, 0mm), total=23)
  via.unite(via_1..via_6, via_6_1..via_6_16, via_6_16_1..via_6_16_22)
  via_7 [copper] = via.duplicate_mirror(point=(0mm, 0mm, 0mm), normal=(0mm, 1mm, 0mm))
  waveport1 = rectangle(corner=(- m_length/2, - w5 /2, - m_thickness /2 - line_thickness), y_size=w5, z_size=m_thickness+ line_thickness*2)
  waveport_1 [pec] = box(corner=(- m_length/2, - w5 /2, - m_thickness /2 - line_thickness), size=(-0.1mm, w5, m_thickness + line_thickness *2))
  waveport2 = rectangle(corner=(m_length/2, -3* ( 2* gap_width + ML_width ) /2, - m_thickness/2 - line_thickness), y_size=3* ( 2* gap_width + ML_width ), z_size=4*m_thickness)
  waveport_2 [pec] = box(corner=(m_length/2, -3* ( 2* gap_width + ML_width ) /2, - m_thickness/2 - line_thickness), size=(0.1mm, 3* ( 2* gap_width + ML_width ), 4*m_thickness))
  Region [air] = region(percentage_offset=30 on all sides)
boundaries and excitations:
  Rad1: Radiation Objects=Region
  1: Wave Port Objects=waveport1 NumModes=1 Modes{Mode1{CharImp=Zpi}}
  2: Wave Port Objects=waveport2 NumModes=1 Modes{Mode1{CharImp=Zpi}}
setups:
  Setup1: HfssDriven Frequency=15GHz MaxDeltaS=0.02 MaximumPasses=12 MinimumPasses=1 MinimumConvergedPasses=1 PercentRefinement=30 BasisOrder=1 PortAccuracy=2
    sweep Sweep: 12GHz to 18GHz, 201 points; Type=Interpolating InterpTolerance=0.5 InterpMaxSolns=250 InterpUsePortImped=false PassivityErrorTolerance=0.0001
source amplitudes:
  1:1: 1W 0deg
  2:1: 0W 0deg
reports:
  S Parameter Plot 1: dB(S(1,1)), dB(S(2,1)) vs Freq on Setup1 : Sweep; markers MY1 at y=-1
